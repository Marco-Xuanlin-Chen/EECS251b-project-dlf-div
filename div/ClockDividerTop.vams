`include "constants.vams"
`include "disciplines.vams"
`timescale 10ps / 1ps

module ClockDividerTop (gnd, clk, reset, en, sel);
    electrical gnd;
    ground gnd;
    reg clk, reset, en;
    reg[4:0] sel;

    initial begin
	clk = 0;
	reset = 1;
	#100
	reset = 0;
    end

    ClockDivider Div (clock(clk), io_div_clk_div(clk), io_sel_clk_div(sel), io_rst(reset), io_en(en));

endmodule
